ADE simulation setup
Run mode: Single Run, Sweeps and Corners
Tests:
  bag_testbenches_kh:tia_noise_tb:1: bag_testbenches_kh/tia_noise_tb/schematic, simulator spectre
