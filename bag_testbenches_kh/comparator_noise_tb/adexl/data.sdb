ADE simulation setup
Run mode: Single Run, Sweeps and Corners
Tests:
  bag_testbenches_kh:comparator_noise_tb:1: bag_testbenches_kh/comparator_noise_tb/schematic, simulator spectre
    Outputs: VO
Global variables:
  Tper = 100p
  cload = 10f
  vcm = 0.6
  vdd = 1.2
  vin = 0
  tdelay = 0
  tr = 5p
