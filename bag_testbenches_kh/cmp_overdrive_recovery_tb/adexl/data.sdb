ADE simulation setup
Run mode: Single Run, Sweeps and Corners
Tests:
  bag_testbenches_kh:cmp_overdrive_recovery_tb:1: bag_testbenches_kh/cmp_overdrive_recovery_tb/schematic, simulator spectre
Global variables:
  cload = 0
  td = 10p
  tf = 10
  Tper = 2n
  tr = 10p
  vdd = 1.2
  vi_final = 50m
  vi_init = 1.2
  c_wait = 4
  vcm = 600m
