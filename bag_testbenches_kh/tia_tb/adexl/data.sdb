ADE simulation setup
Run mode: Single Run, Sweeps and Corners
Tests:
  bag_testbenches_kh:tia_tb:1: bag_testbenches_kh/tia_tb/schematic, simulator spectre
Global variables:
  cload = 75f
  iac = 1
  idc = 10m
  VDD = 1.2
  VSS = 0
  start = 1k
  stop = 1k
