ADE simulation setup
Run mode: Single Run, Sweeps and Corners
Tests:
  bag_testbenches_kh:photonic_link_tb:4: bag_testbenches_kh/photonic_link_AFE_cm_tb/schematic, simulator spectre
